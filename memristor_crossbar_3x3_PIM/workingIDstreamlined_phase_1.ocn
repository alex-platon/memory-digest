;;;;;;;;;;;;;;;;;;;;;;;;;;;;;;;;;;;;;;;;;;;;;;;;;;;;;;;;;;;;;;;;;;;;;;;;;;;;;;;;
;; --- Customization & Setup ---
;;;;;;;;;;;;;;;;;;;;;;;;;;;;;;;;;;;;;;;;;;;;;;;;;;;;;;;;;;;;;;;;;;;;;;;;;;;;;;;;

libName = "memory_manualSim"
cellName = "memristor_crossbar_3x3_PIM"
viewType = "schematic"

;; --- Directory for Generated Script Files and Results ---
scriptFilesDir = "/afs/andrew.cmu.edu/usr14/aplanton/virtuoso/memory_manualSim/memristor_crossbar_3x3_PIM/script_files"

;; --- Initial State Matrix (0=HRS, 1=LRS) ---
initial_states = list(
    list(0 1 0)  ; Row 1
    list(1 0 1)  ; Row 2
    list(0 1 0)  ; Row 3
)

;; --- "Opcode" Control ---
; each event is a list item within eventList to be executed sequentially
; event syntax is ("[cellIndex]" [read/write] [0/1 (write value only if event is write) ])
read = "read"
write = "write"
eventList = list(
    list("C11" read)
    list("C11" write 1)
    list("C11" read)
	list("C13" read)
    list("C13" write 1)
    list("C13" read)
	list("C22" read)
    list("C22" write 1)
    list("C22" read)
	list("C31" read)
    list("C31" write 1)
    list("C31" read)
	list("C33" read)
    list("C33" write 1)
    list("C33" read)
)

;; --- Voltage & Timing Parameters ---
V_read    = 0.2     ; Read voltage [V]
V_set     = -1.7    ; Set voltage [V]
V_reset   = 0.5     ; Reset voltage [V]
V_wl_on   = 2.0     ; Wordline/Select Line ON voltage [V]
t_rise_fall = "100n"  ; Rise/fall time for all pulses
t_total_pulse_width = "10u" ; Width of each read/write pulse (including one t_rise_fall period)

;; --- Memristor Parameters ---
R_on = 7k
R_off = 400k
V_set_thresh = -1.5
V_reset_thresh = 0.3
t_rise = 100n

;;;;;;;;;;;;;;;;;;;;;;;;;;;;;;;;;;;;;;;;;;;;;;;;;;;;;;;;;;;;;;;;;;;;;;;;;;;;;;;;
;; --- Main Script Logic ---
;;;;;;;;;;;;;;;;;;;;;;;;;;;;;;;;;;;;;;;;;;;;;;;;;;;;;;;;;;;;;;;;;;;;;;;;;;;;;;;;

procedure( writeInitialStateFile(states_matrix script_dir)
    let( (output_port row_index col_index state file_path)

        ;; Construct the full path for the output file
        file_path = strcat(script_dir "/setInitialCellStates.scs")

        ;; Open the file in write mode. If it exists, it will be overwritten.
        output_port = outfile(file_path "w")

        ;; Check if the file was opened successfully
        if( output_port then
            ;; Write the mandatory simulator language line at the top of the file
            fprintf(output_port "simulator lang=spectre\n")

            ;; Iterate through each row of the initial_states matrix
            for( row_index 1 3
                ;; Iterate through each column in the current row
                for( col_index 1 3
                    ;; Get the state (0 or 1) for the current cell
                    ;; nth(n list) gets the nth element (0-indexed)
                    ;; so we use rowIndex-1 and colIndex-1
                    state = nth(col_index - 1, nth(row_index - 1, states_matrix))

                    ;; Print the formatted 'alter' statement to the file
                    fprintf(output_port "initC%d%d alter sub=C%d%d param=initial_state value=%d\n",
                        row_index, col_index, row_index, col_index, state)
                )
            )

            ;; Close the file port to ensure all content is written
            close(output_port)
            printf("Successfully wrote initial states to %s\n", file_path)
        else
            ;; Print an error message if the file could not be opened
            printf("Error: Could not open file for writing: %s\n", file_path)
        )
    )
)

procedure( writePwlFiles(events script_dir)
    let( (line_names line_data last_voltages currentTime riseFallTime totalPulseWidth waveforms_dir)

        ;; --- Initialization ---
        line_names = '("BL1" "BL2" "BL3" "WL1" "WL2" "WL3" "SL1" "SL2" "SL3")
        line_data = makeTable("line_data" nil)
        last_voltages = makeTable("last_voltages" 0.0) ; All lines start at 0V
        currentTime = 0.0

        ;; Create a list of points for each line, starting with (0 0)
        foreach(name line_names
            line_data[name] = list(list(0.0 0.0))
        )

        ;; Create the output directory if it doesn't exist
        waveforms_dir = strcat(script_dir "/waveforms/")
        unless(isDir(waveforms_dir) createDir(waveforms_dir))

        ;; Convert timing strings to numeric values by directly accessing global variables
        riseFallTime = evalstring(t_rise_fall)
        totalPulseWidth = evalstring(t_total_pulse_width)

        ;; --- Event Processing Loop ---
        foreach(event events
            let( (cellIndex operation writeValue row col active_bl active_wl bl_voltage wl_voltage time_after_rise time_after_pulse)

                ;; Decode the event from the list
                cellIndex = car(event)
                operation = cadr(event)
                writeValue = caddr(event)

                ;; Parse cellIndex string "C<row><col>" to get row and column numbers
                row = atoi(substring(cellIndex 2 1))
                col = atoi(substring(cellIndex 3 1))

			    active_bl = sprintf(nil "BL%d" col)
				active_wl = sprintf(nil "WL%d" row)

                ;; Determine the target voltage for the active Bitline based on the operation
                if( operation == "read" then
                    bl_voltage = V_read
                else ; write operation
                    if( writeValue == 1 then
                        bl_voltage = V_set
                    else
                        bl_voltage = V_reset
                    )
                )
                ;; The active Wordline is always turned on
                wl_voltage = V_wl_on

                ;; Calculate time points for the current pulse
                time_after_rise = currentTime + riseFallTime
                time_after_pulse = currentTime + totalPulseWidth

                ;; --- Update Waveform Data for ALL lines ---
                foreach( name line_names
                    let( (target_voltage)
                        ;; Determine the target voltage for this specific line during this pulse
                        cond(
                            (name == active_bl target_voltage = bl_voltage)
                            (name == active_wl target_voltage = wl_voltage)
                            (t target_voltage = 0.0) ; All other lines are inactive (0V)
                        )

                        ;; Add points for the pulse transition and hold period
                        line_data[name] = append(line_data[name] list(list(time_after_rise target_voltage) list(time_after_pulse target_voltage)))
                    )
                )

                ;; Advance the simulation time to the end of the current pulse
                currentTime = time_after_pulse
            )
        )

        ;; --- File Writing and Content Logging ---
        foreach(name line_names
            let( (file_path output_port points_to_write prev_point)
                file_path = strcat(waveforms_dir "pwl_" name ".txt")
                output_port = outfile(file_path "w")

                if( output_port then
                    ;; To avoid redundant points, filter the list before writing
                    points_to_write = nil
                    prev_point = list(-1 -1) ; Initialize with a value that can't exist
                    foreach(point line_data[name]
                        unless(equal(point prev_point)
                            points_to_write = append1(points_to_write point)
                        )
                        prev_point = point
                    )

                    ;; If a line was never activated, its file should only contain "0 0"
                    if( length(points_to_write) > 1 && forall(p points_to_write cadr(p)==0.0) then
                        points_to_write = list(list(0.0 0.0))
                    )

                    ;; Write the cleaned-up points to the file
                    foreach(point points_to_write
                        fprintf(output_port "%g %g\n" car(point) cadr(point))
                    )
                    close(output_port)

                    ;; Print the contents of the file to the log for verification
                    printf("\n--- Contents of %s ---\n", file_path)
                    foreach(point points_to_write
                        printf("%g %g\n" car(point) cadr(point))
                    )
                    printf("----------------------------------------\n")

                else
                    printf("Error: Could not open file for writing: %s\n", file_path)
                )
            )
        )
        printf("\nSuccessfully wrote 9 PWL waveform files to %s\n", waveforms_dir)
    )
)

;; --- Execute Procedures ---
;; 1. Call the procedure to write the initial state settings
writeInitialStateFile(initial_states scriptFilesDir)

;; 2. Call the procedure to generate the PWL stimulus files
writePwlFiles(eventList scriptFilesDir)

simulator('spectre)
design(libName cellName viewType)
resultsDir(scriptFilesDir)
path(
"/afs/ece.cmu.edu/class/ece622/cad_setup/gpdk045_v_2_0/models/spectre"
scriptFilesDir
)
desVar("R_on" R_on "R_off" R_off "V_set_thresh" V_set_thresh "V_reset_thresh" V_reset_thresh "t_rise" t_rise)
definitionFile(
"./setInitialCellStates.scs"
)

total_tran_duration = length(eventList) * evalstring(t_total_pulse_width) ;calculate tran analysis stop time
analysis('tran ?stop sprintf(nil "%n" total_tran_duration)  ?errpreset "conservative"  ?maxstep "20n"  ?save "all"  )
temp( 27 )
createNetlist()
run()
selectResult( 'tran )
awvCreatePlotWindow()
